Textbook transmission-gate XOR, no new topology
VDD vdd 0 1.8
VA a 0 0
VB b 0 0
MPA ab a vdd vdd PGEN W=5u L=1u
MNA ab a 0 0 NGEN W=2u L=1u
MPB bb b vdd vdd PGEN W=5u L=1u
MNB bb b 0 0 NGEN W=2u L=1u
MNT out ab b 0 NGEN W=2u L=1u
MPT out a b vdd PGEN W=5u L=1u
MNF out a bb 0 NGEN W=2u L=1u
MPF out ab bb vdd PGEN W=5u L=1u
CL out 0 1p
RL out 0 10000
.model NGEN NMOS (LEVEL=1 VTO=0.45 KP=150u LAMBDA=0.02)
.model PGEN PMOS (LEVEL=1 VTO=-0.45 KP=60u LAMBDA=0.02)
.options reltol=1e-7 abstol=1e-14 vntol=1e-9 gmin=1e-12
.temp 27
.end
