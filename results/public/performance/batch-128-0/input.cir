Generic diode bank with 128 branches
VIN in 0 0.8
.model DB D(IS=1e-12 N=1.2 RS=20)
.options reltol=1e-7 abstol=1e-14 vntol=1e-9 gmin=1e-12
R0 in out 1000
D0 out 0 DB
R1 in n1 1001
D1 n1 0 DB
R2 in n2 1002
D2 n2 0 DB
R3 in n3 1003
D3 n3 0 DB
R4 in n4 1004
D4 n4 0 DB
R5 in n5 1005
D5 n5 0 DB
R6 in n6 1006
D6 n6 0 DB
R7 in n7 1007
D7 n7 0 DB
R8 in n8 1008
D8 n8 0 DB
R9 in n9 1009
D9 n9 0 DB
R10 in n10 1010
D10 n10 0 DB
R11 in n11 1011
D11 n11 0 DB
R12 in n12 1012
D12 n12 0 DB
R13 in n13 1013
D13 n13 0 DB
R14 in n14 1014
D14 n14 0 DB
R15 in n15 1015
D15 n15 0 DB
R16 in n16 1016
D16 n16 0 DB
R17 in n17 1000
D17 n17 0 DB
R18 in n18 1001
D18 n18 0 DB
R19 in n19 1002
D19 n19 0 DB
R20 in n20 1003
D20 n20 0 DB
R21 in n21 1004
D21 n21 0 DB
R22 in n22 1005
D22 n22 0 DB
R23 in n23 1006
D23 n23 0 DB
R24 in n24 1007
D24 n24 0 DB
R25 in n25 1008
D25 n25 0 DB
R26 in n26 1009
D26 n26 0 DB
R27 in n27 1010
D27 n27 0 DB
R28 in n28 1011
D28 n28 0 DB
R29 in n29 1012
D29 n29 0 DB
R30 in n30 1013
D30 n30 0 DB
R31 in n31 1014
D31 n31 0 DB
R32 in n32 1015
D32 n32 0 DB
R33 in n33 1016
D33 n33 0 DB
R34 in n34 1000
D34 n34 0 DB
R35 in n35 1001
D35 n35 0 DB
R36 in n36 1002
D36 n36 0 DB
R37 in n37 1003
D37 n37 0 DB
R38 in n38 1004
D38 n38 0 DB
R39 in n39 1005
D39 n39 0 DB
R40 in n40 1006
D40 n40 0 DB
R41 in n41 1007
D41 n41 0 DB
R42 in n42 1008
D42 n42 0 DB
R43 in n43 1009
D43 n43 0 DB
R44 in n44 1010
D44 n44 0 DB
R45 in n45 1011
D45 n45 0 DB
R46 in n46 1012
D46 n46 0 DB
R47 in n47 1013
D47 n47 0 DB
R48 in n48 1014
D48 n48 0 DB
R49 in n49 1015
D49 n49 0 DB
R50 in n50 1016
D50 n50 0 DB
R51 in n51 1000
D51 n51 0 DB
R52 in n52 1001
D52 n52 0 DB
R53 in n53 1002
D53 n53 0 DB
R54 in n54 1003
D54 n54 0 DB
R55 in n55 1004
D55 n55 0 DB
R56 in n56 1005
D56 n56 0 DB
R57 in n57 1006
D57 n57 0 DB
R58 in n58 1007
D58 n58 0 DB
R59 in n59 1008
D59 n59 0 DB
R60 in n60 1009
D60 n60 0 DB
R61 in n61 1010
D61 n61 0 DB
R62 in n62 1011
D62 n62 0 DB
R63 in n63 1012
D63 n63 0 DB
R64 in n64 1013
D64 n64 0 DB
R65 in n65 1014
D65 n65 0 DB
R66 in n66 1015
D66 n66 0 DB
R67 in n67 1016
D67 n67 0 DB
R68 in n68 1000
D68 n68 0 DB
R69 in n69 1001
D69 n69 0 DB
R70 in n70 1002
D70 n70 0 DB
R71 in n71 1003
D71 n71 0 DB
R72 in n72 1004
D72 n72 0 DB
R73 in n73 1005
D73 n73 0 DB
R74 in n74 1006
D74 n74 0 DB
R75 in n75 1007
D75 n75 0 DB
R76 in n76 1008
D76 n76 0 DB
R77 in n77 1009
D77 n77 0 DB
R78 in n78 1010
D78 n78 0 DB
R79 in n79 1011
D79 n79 0 DB
R80 in n80 1012
D80 n80 0 DB
R81 in n81 1013
D81 n81 0 DB
R82 in n82 1014
D82 n82 0 DB
R83 in n83 1015
D83 n83 0 DB
R84 in n84 1016
D84 n84 0 DB
R85 in n85 1000
D85 n85 0 DB
R86 in n86 1001
D86 n86 0 DB
R87 in n87 1002
D87 n87 0 DB
R88 in n88 1003
D88 n88 0 DB
R89 in n89 1004
D89 n89 0 DB
R90 in n90 1005
D90 n90 0 DB
R91 in n91 1006
D91 n91 0 DB
R92 in n92 1007
D92 n92 0 DB
R93 in n93 1008
D93 n93 0 DB
R94 in n94 1009
D94 n94 0 DB
R95 in n95 1010
D95 n95 0 DB
R96 in n96 1011
D96 n96 0 DB
R97 in n97 1012
D97 n97 0 DB
R98 in n98 1013
D98 n98 0 DB
R99 in n99 1014
D99 n99 0 DB
R100 in n100 1015
D100 n100 0 DB
R101 in n101 1016
D101 n101 0 DB
R102 in n102 1000
D102 n102 0 DB
R103 in n103 1001
D103 n103 0 DB
R104 in n104 1002
D104 n104 0 DB
R105 in n105 1003
D105 n105 0 DB
R106 in n106 1004
D106 n106 0 DB
R107 in n107 1005
D107 n107 0 DB
R108 in n108 1006
D108 n108 0 DB
R109 in n109 1007
D109 n109 0 DB
R110 in n110 1008
D110 n110 0 DB
R111 in n111 1009
D111 n111 0 DB
R112 in n112 1010
D112 n112 0 DB
R113 in n113 1011
D113 n113 0 DB
R114 in n114 1012
D114 n114 0 DB
R115 in n115 1013
D115 n115 0 DB
R116 in n116 1014
D116 n116 0 DB
R117 in n117 1015
D117 n117 0 DB
R118 in n118 1016
D118 n118 0 DB
R119 in n119 1000
D119 n119 0 DB
R120 in n120 1001
D120 n120 0 DB
R121 in n121 1002
D121 n121 0 DB
R122 in n122 1003
D122 n122 0 DB
R123 in n123 1004
D123 n123 0 DB
R124 in n124 1005
D124 n124 0 DB
R125 in n125 1006
D125 n125 0 DB
R126 in n126 1007
D126 n126 0 DB
R127 in n127 1008
D127 n127 0 DB
.control
set noaskquit
set wr_singlescale
set wr_vecnames
set numdgt=15
dc VIN 0.4 0.8 0.05
wrdata result.tsv v(out)
quit
.endc
.end
