Generic diode bank with 512 branches
VIN in 0 0.8
.model DB D(IS=1e-12 N=1.2 RS=20)
.options reltol=1e-7 abstol=1e-14 vntol=1e-9 gmin=1e-12
R0 in out 1000
D0 out 0 DB
R1 in n1 1001
D1 n1 0 DB
R2 in n2 1002
D2 n2 0 DB
R3 in n3 1003
D3 n3 0 DB
R4 in n4 1004
D4 n4 0 DB
R5 in n5 1005
D5 n5 0 DB
R6 in n6 1006
D6 n6 0 DB
R7 in n7 1007
D7 n7 0 DB
R8 in n8 1008
D8 n8 0 DB
R9 in n9 1009
D9 n9 0 DB
R10 in n10 1010
D10 n10 0 DB
R11 in n11 1011
D11 n11 0 DB
R12 in n12 1012
D12 n12 0 DB
R13 in n13 1013
D13 n13 0 DB
R14 in n14 1014
D14 n14 0 DB
R15 in n15 1015
D15 n15 0 DB
R16 in n16 1016
D16 n16 0 DB
R17 in n17 1000
D17 n17 0 DB
R18 in n18 1001
D18 n18 0 DB
R19 in n19 1002
D19 n19 0 DB
R20 in n20 1003
D20 n20 0 DB
R21 in n21 1004
D21 n21 0 DB
R22 in n22 1005
D22 n22 0 DB
R23 in n23 1006
D23 n23 0 DB
R24 in n24 1007
D24 n24 0 DB
R25 in n25 1008
D25 n25 0 DB
R26 in n26 1009
D26 n26 0 DB
R27 in n27 1010
D27 n27 0 DB
R28 in n28 1011
D28 n28 0 DB
R29 in n29 1012
D29 n29 0 DB
R30 in n30 1013
D30 n30 0 DB
R31 in n31 1014
D31 n31 0 DB
R32 in n32 1015
D32 n32 0 DB
R33 in n33 1016
D33 n33 0 DB
R34 in n34 1000
D34 n34 0 DB
R35 in n35 1001
D35 n35 0 DB
R36 in n36 1002
D36 n36 0 DB
R37 in n37 1003
D37 n37 0 DB
R38 in n38 1004
D38 n38 0 DB
R39 in n39 1005
D39 n39 0 DB
R40 in n40 1006
D40 n40 0 DB
R41 in n41 1007
D41 n41 0 DB
R42 in n42 1008
D42 n42 0 DB
R43 in n43 1009
D43 n43 0 DB
R44 in n44 1010
D44 n44 0 DB
R45 in n45 1011
D45 n45 0 DB
R46 in n46 1012
D46 n46 0 DB
R47 in n47 1013
D47 n47 0 DB
R48 in n48 1014
D48 n48 0 DB
R49 in n49 1015
D49 n49 0 DB
R50 in n50 1016
D50 n50 0 DB
R51 in n51 1000
D51 n51 0 DB
R52 in n52 1001
D52 n52 0 DB
R53 in n53 1002
D53 n53 0 DB
R54 in n54 1003
D54 n54 0 DB
R55 in n55 1004
D55 n55 0 DB
R56 in n56 1005
D56 n56 0 DB
R57 in n57 1006
D57 n57 0 DB
R58 in n58 1007
D58 n58 0 DB
R59 in n59 1008
D59 n59 0 DB
R60 in n60 1009
D60 n60 0 DB
R61 in n61 1010
D61 n61 0 DB
R62 in n62 1011
D62 n62 0 DB
R63 in n63 1012
D63 n63 0 DB
R64 in n64 1013
D64 n64 0 DB
R65 in n65 1014
D65 n65 0 DB
R66 in n66 1015
D66 n66 0 DB
R67 in n67 1016
D67 n67 0 DB
R68 in n68 1000
D68 n68 0 DB
R69 in n69 1001
D69 n69 0 DB
R70 in n70 1002
D70 n70 0 DB
R71 in n71 1003
D71 n71 0 DB
R72 in n72 1004
D72 n72 0 DB
R73 in n73 1005
D73 n73 0 DB
R74 in n74 1006
D74 n74 0 DB
R75 in n75 1007
D75 n75 0 DB
R76 in n76 1008
D76 n76 0 DB
R77 in n77 1009
D77 n77 0 DB
R78 in n78 1010
D78 n78 0 DB
R79 in n79 1011
D79 n79 0 DB
R80 in n80 1012
D80 n80 0 DB
R81 in n81 1013
D81 n81 0 DB
R82 in n82 1014
D82 n82 0 DB
R83 in n83 1015
D83 n83 0 DB
R84 in n84 1016
D84 n84 0 DB
R85 in n85 1000
D85 n85 0 DB
R86 in n86 1001
D86 n86 0 DB
R87 in n87 1002
D87 n87 0 DB
R88 in n88 1003
D88 n88 0 DB
R89 in n89 1004
D89 n89 0 DB
R90 in n90 1005
D90 n90 0 DB
R91 in n91 1006
D91 n91 0 DB
R92 in n92 1007
D92 n92 0 DB
R93 in n93 1008
D93 n93 0 DB
R94 in n94 1009
D94 n94 0 DB
R95 in n95 1010
D95 n95 0 DB
R96 in n96 1011
D96 n96 0 DB
R97 in n97 1012
D97 n97 0 DB
R98 in n98 1013
D98 n98 0 DB
R99 in n99 1014
D99 n99 0 DB
R100 in n100 1015
D100 n100 0 DB
R101 in n101 1016
D101 n101 0 DB
R102 in n102 1000
D102 n102 0 DB
R103 in n103 1001
D103 n103 0 DB
R104 in n104 1002
D104 n104 0 DB
R105 in n105 1003
D105 n105 0 DB
R106 in n106 1004
D106 n106 0 DB
R107 in n107 1005
D107 n107 0 DB
R108 in n108 1006
D108 n108 0 DB
R109 in n109 1007
D109 n109 0 DB
R110 in n110 1008
D110 n110 0 DB
R111 in n111 1009
D111 n111 0 DB
R112 in n112 1010
D112 n112 0 DB
R113 in n113 1011
D113 n113 0 DB
R114 in n114 1012
D114 n114 0 DB
R115 in n115 1013
D115 n115 0 DB
R116 in n116 1014
D116 n116 0 DB
R117 in n117 1015
D117 n117 0 DB
R118 in n118 1016
D118 n118 0 DB
R119 in n119 1000
D119 n119 0 DB
R120 in n120 1001
D120 n120 0 DB
R121 in n121 1002
D121 n121 0 DB
R122 in n122 1003
D122 n122 0 DB
R123 in n123 1004
D123 n123 0 DB
R124 in n124 1005
D124 n124 0 DB
R125 in n125 1006
D125 n125 0 DB
R126 in n126 1007
D126 n126 0 DB
R127 in n127 1008
D127 n127 0 DB
R128 in n128 1009
D128 n128 0 DB
R129 in n129 1010
D129 n129 0 DB
R130 in n130 1011
D130 n130 0 DB
R131 in n131 1012
D131 n131 0 DB
R132 in n132 1013
D132 n132 0 DB
R133 in n133 1014
D133 n133 0 DB
R134 in n134 1015
D134 n134 0 DB
R135 in n135 1016
D135 n135 0 DB
R136 in n136 1000
D136 n136 0 DB
R137 in n137 1001
D137 n137 0 DB
R138 in n138 1002
D138 n138 0 DB
R139 in n139 1003
D139 n139 0 DB
R140 in n140 1004
D140 n140 0 DB
R141 in n141 1005
D141 n141 0 DB
R142 in n142 1006
D142 n142 0 DB
R143 in n143 1007
D143 n143 0 DB
R144 in n144 1008
D144 n144 0 DB
R145 in n145 1009
D145 n145 0 DB
R146 in n146 1010
D146 n146 0 DB
R147 in n147 1011
D147 n147 0 DB
R148 in n148 1012
D148 n148 0 DB
R149 in n149 1013
D149 n149 0 DB
R150 in n150 1014
D150 n150 0 DB
R151 in n151 1015
D151 n151 0 DB
R152 in n152 1016
D152 n152 0 DB
R153 in n153 1000
D153 n153 0 DB
R154 in n154 1001
D154 n154 0 DB
R155 in n155 1002
D155 n155 0 DB
R156 in n156 1003
D156 n156 0 DB
R157 in n157 1004
D157 n157 0 DB
R158 in n158 1005
D158 n158 0 DB
R159 in n159 1006
D159 n159 0 DB
R160 in n160 1007
D160 n160 0 DB
R161 in n161 1008
D161 n161 0 DB
R162 in n162 1009
D162 n162 0 DB
R163 in n163 1010
D163 n163 0 DB
R164 in n164 1011
D164 n164 0 DB
R165 in n165 1012
D165 n165 0 DB
R166 in n166 1013
D166 n166 0 DB
R167 in n167 1014
D167 n167 0 DB
R168 in n168 1015
D168 n168 0 DB
R169 in n169 1016
D169 n169 0 DB
R170 in n170 1000
D170 n170 0 DB
R171 in n171 1001
D171 n171 0 DB
R172 in n172 1002
D172 n172 0 DB
R173 in n173 1003
D173 n173 0 DB
R174 in n174 1004
D174 n174 0 DB
R175 in n175 1005
D175 n175 0 DB
R176 in n176 1006
D176 n176 0 DB
R177 in n177 1007
D177 n177 0 DB
R178 in n178 1008
D178 n178 0 DB
R179 in n179 1009
D179 n179 0 DB
R180 in n180 1010
D180 n180 0 DB
R181 in n181 1011
D181 n181 0 DB
R182 in n182 1012
D182 n182 0 DB
R183 in n183 1013
D183 n183 0 DB
R184 in n184 1014
D184 n184 0 DB
R185 in n185 1015
D185 n185 0 DB
R186 in n186 1016
D186 n186 0 DB
R187 in n187 1000
D187 n187 0 DB
R188 in n188 1001
D188 n188 0 DB
R189 in n189 1002
D189 n189 0 DB
R190 in n190 1003
D190 n190 0 DB
R191 in n191 1004
D191 n191 0 DB
R192 in n192 1005
D192 n192 0 DB
R193 in n193 1006
D193 n193 0 DB
R194 in n194 1007
D194 n194 0 DB
R195 in n195 1008
D195 n195 0 DB
R196 in n196 1009
D196 n196 0 DB
R197 in n197 1010
D197 n197 0 DB
R198 in n198 1011
D198 n198 0 DB
R199 in n199 1012
D199 n199 0 DB
R200 in n200 1013
D200 n200 0 DB
R201 in n201 1014
D201 n201 0 DB
R202 in n202 1015
D202 n202 0 DB
R203 in n203 1016
D203 n203 0 DB
R204 in n204 1000
D204 n204 0 DB
R205 in n205 1001
D205 n205 0 DB
R206 in n206 1002
D206 n206 0 DB
R207 in n207 1003
D207 n207 0 DB
R208 in n208 1004
D208 n208 0 DB
R209 in n209 1005
D209 n209 0 DB
R210 in n210 1006
D210 n210 0 DB
R211 in n211 1007
D211 n211 0 DB
R212 in n212 1008
D212 n212 0 DB
R213 in n213 1009
D213 n213 0 DB
R214 in n214 1010
D214 n214 0 DB
R215 in n215 1011
D215 n215 0 DB
R216 in n216 1012
D216 n216 0 DB
R217 in n217 1013
D217 n217 0 DB
R218 in n218 1014
D218 n218 0 DB
R219 in n219 1015
D219 n219 0 DB
R220 in n220 1016
D220 n220 0 DB
R221 in n221 1000
D221 n221 0 DB
R222 in n222 1001
D222 n222 0 DB
R223 in n223 1002
D223 n223 0 DB
R224 in n224 1003
D224 n224 0 DB
R225 in n225 1004
D225 n225 0 DB
R226 in n226 1005
D226 n226 0 DB
R227 in n227 1006
D227 n227 0 DB
R228 in n228 1007
D228 n228 0 DB
R229 in n229 1008
D229 n229 0 DB
R230 in n230 1009
D230 n230 0 DB
R231 in n231 1010
D231 n231 0 DB
R232 in n232 1011
D232 n232 0 DB
R233 in n233 1012
D233 n233 0 DB
R234 in n234 1013
D234 n234 0 DB
R235 in n235 1014
D235 n235 0 DB
R236 in n236 1015
D236 n236 0 DB
R237 in n237 1016
D237 n237 0 DB
R238 in n238 1000
D238 n238 0 DB
R239 in n239 1001
D239 n239 0 DB
R240 in n240 1002
D240 n240 0 DB
R241 in n241 1003
D241 n241 0 DB
R242 in n242 1004
D242 n242 0 DB
R243 in n243 1005
D243 n243 0 DB
R244 in n244 1006
D244 n244 0 DB
R245 in n245 1007
D245 n245 0 DB
R246 in n246 1008
D246 n246 0 DB
R247 in n247 1009
D247 n247 0 DB
R248 in n248 1010
D248 n248 0 DB
R249 in n249 1011
D249 n249 0 DB
R250 in n250 1012
D250 n250 0 DB
R251 in n251 1013
D251 n251 0 DB
R252 in n252 1014
D252 n252 0 DB
R253 in n253 1015
D253 n253 0 DB
R254 in n254 1016
D254 n254 0 DB
R255 in n255 1000
D255 n255 0 DB
R256 in n256 1001
D256 n256 0 DB
R257 in n257 1002
D257 n257 0 DB
R258 in n258 1003
D258 n258 0 DB
R259 in n259 1004
D259 n259 0 DB
R260 in n260 1005
D260 n260 0 DB
R261 in n261 1006
D261 n261 0 DB
R262 in n262 1007
D262 n262 0 DB
R263 in n263 1008
D263 n263 0 DB
R264 in n264 1009
D264 n264 0 DB
R265 in n265 1010
D265 n265 0 DB
R266 in n266 1011
D266 n266 0 DB
R267 in n267 1012
D267 n267 0 DB
R268 in n268 1013
D268 n268 0 DB
R269 in n269 1014
D269 n269 0 DB
R270 in n270 1015
D270 n270 0 DB
R271 in n271 1016
D271 n271 0 DB
R272 in n272 1000
D272 n272 0 DB
R273 in n273 1001
D273 n273 0 DB
R274 in n274 1002
D274 n274 0 DB
R275 in n275 1003
D275 n275 0 DB
R276 in n276 1004
D276 n276 0 DB
R277 in n277 1005
D277 n277 0 DB
R278 in n278 1006
D278 n278 0 DB
R279 in n279 1007
D279 n279 0 DB
R280 in n280 1008
D280 n280 0 DB
R281 in n281 1009
D281 n281 0 DB
R282 in n282 1010
D282 n282 0 DB
R283 in n283 1011
D283 n283 0 DB
R284 in n284 1012
D284 n284 0 DB
R285 in n285 1013
D285 n285 0 DB
R286 in n286 1014
D286 n286 0 DB
R287 in n287 1015
D287 n287 0 DB
R288 in n288 1016
D288 n288 0 DB
R289 in n289 1000
D289 n289 0 DB
R290 in n290 1001
D290 n290 0 DB
R291 in n291 1002
D291 n291 0 DB
R292 in n292 1003
D292 n292 0 DB
R293 in n293 1004
D293 n293 0 DB
R294 in n294 1005
D294 n294 0 DB
R295 in n295 1006
D295 n295 0 DB
R296 in n296 1007
D296 n296 0 DB
R297 in n297 1008
D297 n297 0 DB
R298 in n298 1009
D298 n298 0 DB
R299 in n299 1010
D299 n299 0 DB
R300 in n300 1011
D300 n300 0 DB
R301 in n301 1012
D301 n301 0 DB
R302 in n302 1013
D302 n302 0 DB
R303 in n303 1014
D303 n303 0 DB
R304 in n304 1015
D304 n304 0 DB
R305 in n305 1016
D305 n305 0 DB
R306 in n306 1000
D306 n306 0 DB
R307 in n307 1001
D307 n307 0 DB
R308 in n308 1002
D308 n308 0 DB
R309 in n309 1003
D309 n309 0 DB
R310 in n310 1004
D310 n310 0 DB
R311 in n311 1005
D311 n311 0 DB
R312 in n312 1006
D312 n312 0 DB
R313 in n313 1007
D313 n313 0 DB
R314 in n314 1008
D314 n314 0 DB
R315 in n315 1009
D315 n315 0 DB
R316 in n316 1010
D316 n316 0 DB
R317 in n317 1011
D317 n317 0 DB
R318 in n318 1012
D318 n318 0 DB
R319 in n319 1013
D319 n319 0 DB
R320 in n320 1014
D320 n320 0 DB
R321 in n321 1015
D321 n321 0 DB
R322 in n322 1016
D322 n322 0 DB
R323 in n323 1000
D323 n323 0 DB
R324 in n324 1001
D324 n324 0 DB
R325 in n325 1002
D325 n325 0 DB
R326 in n326 1003
D326 n326 0 DB
R327 in n327 1004
D327 n327 0 DB
R328 in n328 1005
D328 n328 0 DB
R329 in n329 1006
D329 n329 0 DB
R330 in n330 1007
D330 n330 0 DB
R331 in n331 1008
D331 n331 0 DB
R332 in n332 1009
D332 n332 0 DB
R333 in n333 1010
D333 n333 0 DB
R334 in n334 1011
D334 n334 0 DB
R335 in n335 1012
D335 n335 0 DB
R336 in n336 1013
D336 n336 0 DB
R337 in n337 1014
D337 n337 0 DB
R338 in n338 1015
D338 n338 0 DB
R339 in n339 1016
D339 n339 0 DB
R340 in n340 1000
D340 n340 0 DB
R341 in n341 1001
D341 n341 0 DB
R342 in n342 1002
D342 n342 0 DB
R343 in n343 1003
D343 n343 0 DB
R344 in n344 1004
D344 n344 0 DB
R345 in n345 1005
D345 n345 0 DB
R346 in n346 1006
D346 n346 0 DB
R347 in n347 1007
D347 n347 0 DB
R348 in n348 1008
D348 n348 0 DB
R349 in n349 1009
D349 n349 0 DB
R350 in n350 1010
D350 n350 0 DB
R351 in n351 1011
D351 n351 0 DB
R352 in n352 1012
D352 n352 0 DB
R353 in n353 1013
D353 n353 0 DB
R354 in n354 1014
D354 n354 0 DB
R355 in n355 1015
D355 n355 0 DB
R356 in n356 1016
D356 n356 0 DB
R357 in n357 1000
D357 n357 0 DB
R358 in n358 1001
D358 n358 0 DB
R359 in n359 1002
D359 n359 0 DB
R360 in n360 1003
D360 n360 0 DB
R361 in n361 1004
D361 n361 0 DB
R362 in n362 1005
D362 n362 0 DB
R363 in n363 1006
D363 n363 0 DB
R364 in n364 1007
D364 n364 0 DB
R365 in n365 1008
D365 n365 0 DB
R366 in n366 1009
D366 n366 0 DB
R367 in n367 1010
D367 n367 0 DB
R368 in n368 1011
D368 n368 0 DB
R369 in n369 1012
D369 n369 0 DB
R370 in n370 1013
D370 n370 0 DB
R371 in n371 1014
D371 n371 0 DB
R372 in n372 1015
D372 n372 0 DB
R373 in n373 1016
D373 n373 0 DB
R374 in n374 1000
D374 n374 0 DB
R375 in n375 1001
D375 n375 0 DB
R376 in n376 1002
D376 n376 0 DB
R377 in n377 1003
D377 n377 0 DB
R378 in n378 1004
D378 n378 0 DB
R379 in n379 1005
D379 n379 0 DB
R380 in n380 1006
D380 n380 0 DB
R381 in n381 1007
D381 n381 0 DB
R382 in n382 1008
D382 n382 0 DB
R383 in n383 1009
D383 n383 0 DB
R384 in n384 1010
D384 n384 0 DB
R385 in n385 1011
D385 n385 0 DB
R386 in n386 1012
D386 n386 0 DB
R387 in n387 1013
D387 n387 0 DB
R388 in n388 1014
D388 n388 0 DB
R389 in n389 1015
D389 n389 0 DB
R390 in n390 1016
D390 n390 0 DB
R391 in n391 1000
D391 n391 0 DB
R392 in n392 1001
D392 n392 0 DB
R393 in n393 1002
D393 n393 0 DB
R394 in n394 1003
D394 n394 0 DB
R395 in n395 1004
D395 n395 0 DB
R396 in n396 1005
D396 n396 0 DB
R397 in n397 1006
D397 n397 0 DB
R398 in n398 1007
D398 n398 0 DB
R399 in n399 1008
D399 n399 0 DB
R400 in n400 1009
D400 n400 0 DB
R401 in n401 1010
D401 n401 0 DB
R402 in n402 1011
D402 n402 0 DB
R403 in n403 1012
D403 n403 0 DB
R404 in n404 1013
D404 n404 0 DB
R405 in n405 1014
D405 n405 0 DB
R406 in n406 1015
D406 n406 0 DB
R407 in n407 1016
D407 n407 0 DB
R408 in n408 1000
D408 n408 0 DB
R409 in n409 1001
D409 n409 0 DB
R410 in n410 1002
D410 n410 0 DB
R411 in n411 1003
D411 n411 0 DB
R412 in n412 1004
D412 n412 0 DB
R413 in n413 1005
D413 n413 0 DB
R414 in n414 1006
D414 n414 0 DB
R415 in n415 1007
D415 n415 0 DB
R416 in n416 1008
D416 n416 0 DB
R417 in n417 1009
D417 n417 0 DB
R418 in n418 1010
D418 n418 0 DB
R419 in n419 1011
D419 n419 0 DB
R420 in n420 1012
D420 n420 0 DB
R421 in n421 1013
D421 n421 0 DB
R422 in n422 1014
D422 n422 0 DB
R423 in n423 1015
D423 n423 0 DB
R424 in n424 1016
D424 n424 0 DB
R425 in n425 1000
D425 n425 0 DB
R426 in n426 1001
D426 n426 0 DB
R427 in n427 1002
D427 n427 0 DB
R428 in n428 1003
D428 n428 0 DB
R429 in n429 1004
D429 n429 0 DB
R430 in n430 1005
D430 n430 0 DB
R431 in n431 1006
D431 n431 0 DB
R432 in n432 1007
D432 n432 0 DB
R433 in n433 1008
D433 n433 0 DB
R434 in n434 1009
D434 n434 0 DB
R435 in n435 1010
D435 n435 0 DB
R436 in n436 1011
D436 n436 0 DB
R437 in n437 1012
D437 n437 0 DB
R438 in n438 1013
D438 n438 0 DB
R439 in n439 1014
D439 n439 0 DB
R440 in n440 1015
D440 n440 0 DB
R441 in n441 1016
D441 n441 0 DB
R442 in n442 1000
D442 n442 0 DB
R443 in n443 1001
D443 n443 0 DB
R444 in n444 1002
D444 n444 0 DB
R445 in n445 1003
D445 n445 0 DB
R446 in n446 1004
D446 n446 0 DB
R447 in n447 1005
D447 n447 0 DB
R448 in n448 1006
D448 n448 0 DB
R449 in n449 1007
D449 n449 0 DB
R450 in n450 1008
D450 n450 0 DB
R451 in n451 1009
D451 n451 0 DB
R452 in n452 1010
D452 n452 0 DB
R453 in n453 1011
D453 n453 0 DB
R454 in n454 1012
D454 n454 0 DB
R455 in n455 1013
D455 n455 0 DB
R456 in n456 1014
D456 n456 0 DB
R457 in n457 1015
D457 n457 0 DB
R458 in n458 1016
D458 n458 0 DB
R459 in n459 1000
D459 n459 0 DB
R460 in n460 1001
D460 n460 0 DB
R461 in n461 1002
D461 n461 0 DB
R462 in n462 1003
D462 n462 0 DB
R463 in n463 1004
D463 n463 0 DB
R464 in n464 1005
D464 n464 0 DB
R465 in n465 1006
D465 n465 0 DB
R466 in n466 1007
D466 n466 0 DB
R467 in n467 1008
D467 n467 0 DB
R468 in n468 1009
D468 n468 0 DB
R469 in n469 1010
D469 n469 0 DB
R470 in n470 1011
D470 n470 0 DB
R471 in n471 1012
D471 n471 0 DB
R472 in n472 1013
D472 n472 0 DB
R473 in n473 1014
D473 n473 0 DB
R474 in n474 1015
D474 n474 0 DB
R475 in n475 1016
D475 n475 0 DB
R476 in n476 1000
D476 n476 0 DB
R477 in n477 1001
D477 n477 0 DB
R478 in n478 1002
D478 n478 0 DB
R479 in n479 1003
D479 n479 0 DB
R480 in n480 1004
D480 n480 0 DB
R481 in n481 1005
D481 n481 0 DB
R482 in n482 1006
D482 n482 0 DB
R483 in n483 1007
D483 n483 0 DB
R484 in n484 1008
D484 n484 0 DB
R485 in n485 1009
D485 n485 0 DB
R486 in n486 1010
D486 n486 0 DB
R487 in n487 1011
D487 n487 0 DB
R488 in n488 1012
D488 n488 0 DB
R489 in n489 1013
D489 n489 0 DB
R490 in n490 1014
D490 n490 0 DB
R491 in n491 1015
D491 n491 0 DB
R492 in n492 1016
D492 n492 0 DB
R493 in n493 1000
D493 n493 0 DB
R494 in n494 1001
D494 n494 0 DB
R495 in n495 1002
D495 n495 0 DB
R496 in n496 1003
D496 n496 0 DB
R497 in n497 1004
D497 n497 0 DB
R498 in n498 1005
D498 n498 0 DB
R499 in n499 1006
D499 n499 0 DB
R500 in n500 1007
D500 n500 0 DB
R501 in n501 1008
D501 n501 0 DB
R502 in n502 1009
D502 n502 0 DB
R503 in n503 1010
D503 n503 0 DB
R504 in n504 1011
D504 n504 0 DB
R505 in n505 1012
D505 n505 0 DB
R506 in n506 1013
D506 n506 0 DB
R507 in n507 1014
D507 n507 0 DB
R508 in n508 1015
D508 n508 0 DB
R509 in n509 1016
D509 n509 0 DB
R510 in n510 1000
D510 n510 0 DB
R511 in n511 1001
D511 n511 0 DB
.control
set noaskquit
set wr_singlescale
set wr_vecnames
set numdgt=15
alter VIN dc=0.8
op
wrdata result.tsv v(out)
quit
.endc
.end
